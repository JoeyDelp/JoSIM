* RC Johnson noise verification
.TEMP 4.2
.NEB 1e6

R1 n1 0 10000
C1 n1 0 1e-9

.TRAN 1e-7 0.05 0 1e-7 0

* Output:
.PRINT V(n1)

.END
