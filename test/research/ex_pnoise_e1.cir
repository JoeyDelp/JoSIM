* PNOISE external test E1: current 1/f noise into a resistor
I1   n   0   PNOISE(1E-12, 1.0, 0, 1E-4, 2.0, 64)
R1   n   0   10K

.TRAN 1E-4 20 0 1E-4 0
.PRINT V(n)

.END
