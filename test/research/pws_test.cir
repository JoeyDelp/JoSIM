I01 0 1 PWS(0 0 62.5p 315u 187.5p -315u 312.5p 315u 437.5p -315u 500p 0)
R01 1 0 2
.tran 0.25p 4n
.print i(I01)
