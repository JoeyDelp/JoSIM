I01 0 1 SIN(0 315u 4g 20p 0 0 4)
R01 1 0 2
.tran 0.25p 4n
.print i(I01)
