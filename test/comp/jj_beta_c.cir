* Set nominal RTYPE=0 damping directly with BETA_C.
.param BETA=1 ICVAL=1u CVAL=0.1p
.model JM JJ(RTYPE=0 IC=ICVAL CAP=CVAL BETA_C=BETA)
V1 N 0 PWL(0 0 100p 1m)
B1 N 0 JM
.tran 0.01p 20p DST
.print V(N) P(B1) I(B1) I(V1)
.end
